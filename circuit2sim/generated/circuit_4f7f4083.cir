* Circuit2Sim - Universal SPICE Netlist
* Model: Project 4f7f4083 Schematic Model
* Compatible with: LTspice, ngspice, PSpice, Multisim, PLECS
* -------------------------------------------------------------

R1 N1_VIN N2 1k
C2 N2 N3 1e-06
R3 N3 N4 1k
C4 N4 N5 1e-06
R5 N5 N6 1000.0
R6 N6 N7 1000.0
R7 N7 N8 1k
R8 N8 N9 10000.0
L9 N9 N10 0.001
R10 N10 N11 1k
R11 N11 N12 10000.0
R12 N12 N13 1k
R13 N13 N14 1000.0
V14 N1_VIN 0 DC 12.0
L15 N14 N15 0.001
* GND16 Reference Ground Node 0
R17 N15 N16 10000.0
L18 N16 N17 0.001
R19 N17 N18 1000.0
R20 N18 N19 1k
C21 N19 N20 1e-06
R22 N20 N21 1000.0
R23 N21 N22 1000.0
* GND24 Reference Ground Node 0
C25 N22 N23 1e-06
C26 N23 N24 1e-06
C27 N24 N25 1e-06
C28 N25 N26 1e-06
C29 N26 N27 1e-07
C30 N27 N28 1e-06
R31 N28 N29 1k
D32 N29 N30 DMOD
.model DMOD D (Is=1e-14 Rs=0.01 N=1 Cjo=2p)
* GND33 Reference Ground Node 0
* GND34 Reference Ground Node 0
C35 N30 N31 1e-06
C36 N31 N32 1e-06
* GND37 Reference Ground Node 0
R38 N32 N33 1k
C39 N33 N34 1e-06
* GND40 Reference Ground Node 0
R41 N34 N35 10000.0
L42 N35 N36 0.001
C43 N36 N37 1e-06
R44 N37 N38 10000.0
* GND45 Reference Ground Node 0
C46 N38 N39 1e-07
R47 N39 N40 10000.0
* GND48 Reference Ground Node 0
C49 N40 N41 1e-07
R50 N41 N42 1k
L51 N42 N43 0.001
R52 N43 N44 1k
R53 N44 N45 1k
L54 N45 N46 0.001
* GND55 Reference Ground Node 0
C56 N46 N47 1e-07
C57 N47 N48 1e-06
C58 N48 N49 1e-07
* GND59 Reference Ground Node 0
C60 N49 N50 1e-07
C61 N50 N51 1e-06
* GND62 Reference Ground Node 0
* GND63 Reference Ground Node 0
* GND64 Reference Ground Node 0
* GND65 Reference Ground Node 0
L66 N51 N52 0.001
* GND67 Reference Ground Node 0
R68 N52 N53 10000.0
R69 N53 N54 1k
* GND70 Reference Ground Node 0
* GND71 Reference Ground Node 0
* GND72 Reference Ground Node 0
C73 N54 N55 1e-06
* GND74 Reference Ground Node 0
C75 N55 N56 1e-06
C76 N56 N57 1e-07
C77 N57 N58 1e-06
C78 N58 N59 1e-06
* GND79 Reference Ground Node 0
R80 N59 N60 10000.0
C81 N60 N61 1e-07
* GND82 Reference Ground Node 0
* GND83 Reference Ground Node 0
* GND84 Reference Ground Node 0
* GND85 Reference Ground Node 0
C86 N61 N62 1e-06
L87 N62 N63 0.001
C88 N63 N64 1e-07
C89 N64 N65 1e-07
C90 N65 N66 1e-06
R91 N66 N67 1k
R92 N67 N68 10000.0
R93 N68 N69 1k
R94 N69 N70 1k
* GND95 Reference Ground Node 0
L96 N70 N71 0.001
* GND97 Reference Ground Node 0
R98 N71 N72 10000.0
C99 N72 N73 1e-06
R100 N73 N74 10000.0
R101 N74 N75 10000.0
* GND102 Reference Ground Node 0
R103 N75 N76 1k
C104 N76 N77 1e-06
L105 N77 N78 0.001
C106 N78 N79 1e-06
* GND107 Reference Ground Node 0
C108 N79 N80 1e-07
R109 N80 N81 10000.0
* GND110 Reference Ground Node 0
C111 N81 N82 1e-07
R112 N82 N83 10000.0
* GND113 Reference Ground Node 0
C114 N83 N84 1e-07
R115 N84 N85 1k
R116 N85 N86 1k
* GND117 Reference Ground Node 0
R118 N86 N87 10000.0
R119 N87 N88 10000.0
* GND120 Reference Ground Node 0
R121 N88 N89 10000.0
C122 N89 N90 1e-06
L123 N90 N91 0.001
* GND124 Reference Ground Node 0
R125 N91 N92 10000.0
* GND126 Reference Ground Node 0
* GND127 Reference Ground Node 0
* GND128 Reference Ground Node 0
L129 N92 N93 0.001
* GND130 Reference Ground Node 0
* GND131 Reference Ground Node 0
L132 N93 N94 0.001
* GND133 Reference Ground Node 0
R134 N94 N95 10000.0
* GND135 Reference Ground Node 0
R136 N95 N96 10000.0
R137 N96 N97 10000.0
* GND138 Reference Ground Node 0
* GND139 Reference Ground Node 0
R140 N97 N98 10000.0
C141 N98 N99 1e-06
R142 N99 N100 10000.0
* GND143 Reference Ground Node 0
* GND144 Reference Ground Node 0
R145 N100 N101 10000.0
* GND146 Reference Ground Node 0
R147 N101 N102 1k
D148 N102 N103 DMOD
.model DMOD D (Is=1e-14 Rs=0.01 N=1 Cjo=2p)
R149 N103 N104 1000.0
* GND150 Reference Ground Node 0
C151 N104 N105 1e-06
C152 N105 N106 1e-07
* GND153 Reference Ground Node 0
R154 N106 N107 1k
* GND155 Reference Ground Node 0
L156 N107 N108 0.001
R157 N108 N109 10000.0
* GND158 Reference Ground Node 0
L159 N109 N110 0.001
C160 N110 N111 1e-06
R161 N111 N112 10000.0
* GND162 Reference Ground Node 0
R163 N112 N113 10000.0
* GND164 Reference Ground Node 0
* GND165 Reference Ground Node 0
C166 N113 N114 1e-06
* GND167 Reference Ground Node 0
* GND168 Reference Ground Node 0
C169 N114 N115 1e-07
C170 N115 N116 1e-06
L171 N116 N117 0.001
* GND172 Reference Ground Node 0
* GND173 Reference Ground Node 0
* GND174 Reference Ground Node 0
R175 N117 N118 10000.0
R176 N118 N119 10000.0
C177 N119 N120 1e-06
C178 N120 N121 1e-06
R179 N121 N122 10000.0
* GND180 Reference Ground Node 0
R181 N122 N123 1k
C182 N123 N124 1e-06
L183 N124 N125 0.001
R184 N125 N126 10000.0
C185 N126 N127 1e-07
* GND186 Reference Ground Node 0
R187 N127 N128 1k
R188 N128 N129 10000.0
* GND189 Reference Ground Node 0
R190 N129 N130 10000.0
R191 N130 N131 1k
R192 N131 N132 1k
* GND193 Reference Ground Node 0
R194 N132 N133 10000.0
* GND195 Reference Ground Node 0
C196 N133 N134 1e-06
* GND197 Reference Ground Node 0
* GND198 Reference Ground Node 0
* GND199 Reference Ground Node 0
* GND200 Reference Ground Node 0
C201 N134 N135 1e-06
* GND202 Reference Ground Node 0
* GND203 Reference Ground Node 0
L204 N135 N136 0.001
* GND205 Reference Ground Node 0
R206 N136 N137 10000.0
C207 N137 N138 1e-07
R208 N138 N139 10000.0
R209 N139 N140 1k
R210 N140 N141 1k
V211 N_NC1 0 DC 12.0
C212 N141 N142 1e-06
* GND213 Reference Ground Node 0
C214 N142 N143 1e-06
* GND215 Reference Ground Node 0
C216 N143 N144 1e-07
R217 N144 N145 1000.0
C218 N145 N146 1e-06
L219 N146 N147 0.001
R220 N147 N148 10000.0
C221 N148 N149 1e-06
C222 N149 N150 1e-06
R223 N150 N151 1k
R224 N151 N152 1k
R225 N152 N153 1k
C226 N153 N154 1e-06
* GND227 Reference Ground Node 0
C228 N154 N155 1e-06
* GND229 Reference Ground Node 0
C230 N155 N156 1e-06
* GND231 Reference Ground Node 0
R232 N156 N157 10000.0
C233 N157 N158 1e-06
* GND234 Reference Ground Node 0
R235 N158 N159 1k
R236 N159 N160 1k
* GND237 Reference Ground Node 0
C238 N160 N161 1e-06
R239 N161 N162 1k
* GND240 Reference Ground Node 0
* GND241 Reference Ground Node 0
* GND242 Reference Ground Node 0
L243 N162 N163 0.001
C244 N163 N164 1e-06
* GND245 Reference Ground Node 0
* GND246 Reference Ground Node 0
R247 N164 N165 1k
R248 N165 N166 10000.0
* GND249 Reference Ground Node 0
R250 N166 N167 10000.0
R251 N167 N168 1k
* GND252 Reference Ground Node 0
C253 N168 N169 1e-06
C254 N169 N170 1e-06
R255 N170 N171 1k
* GND256 Reference Ground Node 0
C257 N171 N172 1e-06
R258 N172 N173 1000.0
* GND259 Reference Ground Node 0
R260 N173 N174 10000.0
* GND261 Reference Ground Node 0
R262 N174 N175 10000.0
* GND263 Reference Ground Node 0
* GND264 Reference Ground Node 0
C265 N175 N176 1e-06
* GND266 Reference Ground Node 0
* GND267 Reference Ground Node 0
* GND268 Reference Ground Node 0
C269 N176 N177 1e-06
L270 N177 N178 0.001
R271 N178 N179 10000.0
C272 N179 N180 1e-07
* GND273 Reference Ground Node 0
* GND274 Reference Ground Node 0
R275 N180 N181 1000.0
L276 N181 N182 0.001
* GND277 Reference Ground Node 0
* GND278 Reference Ground Node 0
L279 N182 N183 0.001
* GND280 Reference Ground Node 0
C281 N183 N184 1e-06
R282 N184 N185 1k
C283 N185 N186 1e-06
R284 N186 N187 10000.0
C285 N187 N188 1e-06
* GND286 Reference Ground Node 0
R287 N188 N189 1k
* GND288 Reference Ground Node 0
* GND289 Reference Ground Node 0
R290 N189 N190 10000.0
* GND291 Reference Ground Node 0
* GND292 Reference Ground Node 0
C293 N190 N191 1e-06
* GND294 Reference Ground Node 0
C295 N191 N192 1e-06
* GND296 Reference Ground Node 0
* GND297 Reference Ground Node 0
* GND298 Reference Ground Node 0
* GND299 Reference Ground Node 0
* GND300 Reference Ground Node 0
* GND301 Reference Ground Node 0
* GND302 Reference Ground Node 0
C303 N192 N193 1e-06
R304 N193 N194 10000.0
R305 N194 N195 10000.0
L306 N195 N196 0.001
* GND307 Reference Ground Node 0
C308 N196 N197 1e-07
* GND309 Reference Ground Node 0
C310 N197 N198 1e-07
* GND311 Reference Ground Node 0
* GND312 Reference Ground Node 0
R313 N198 N199 1000.0
R314 N199 N200 10000.0
C315 N200 N201 1e-06
* GND316 Reference Ground Node 0
R317 N201 N202 10000.0
* GND318 Reference Ground Node 0
* GND319 Reference Ground Node 0
C320 N202 N203 1e-06
* GND321 Reference Ground Node 0
* GND322 Reference Ground Node 0
* GND323 Reference Ground Node 0
C324 N203 N204 1e-06
* GND325 Reference Ground Node 0
R326 N204 N205 10000.0
* GND327 Reference Ground Node 0
* GND328 Reference Ground Node 0
R329 N205 N206 1k
* GND330 Reference Ground Node 0
R331 N206 N207 1k
* GND332 Reference Ground Node 0
R333 N207 N208 1k
R334 N208 N209 10000.0
R335 N209 N210 1k
L336 N210 N211 0.001
R337 N211 N212 1k
R338 N212 0 10000.0
* GND339 Reference Ground Node 0

* Transient analysis: start 0, stop 10ms, step 1us
.tran 1u 10m
.end
